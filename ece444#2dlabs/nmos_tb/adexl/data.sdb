ADE simulation setup
Run mode: Single Run, Sweeps and Corners
Tests:
  ID_VDS: ece444-labs/nmos_tb/schematic, simulator spectre
  Sqrt_ID_VGS: ece444-labs/nmos_tb/schematic, simulator spectre
Global variables:
  vds = 1
  vgs = {From/To}Auto:0:6:1{From/To}
